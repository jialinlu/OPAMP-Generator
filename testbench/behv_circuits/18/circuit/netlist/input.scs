// Generated by amp topo opt program
simulator lang=spectre
global 0
// Header end
parameters c_1_0_0=0.5 r_1_1_0=4.45842 c_1_vo_02=0.5 r_1_vo_02=40.22983 \
    r_1_vo_vo=9.990747 gm_1_vo_1=0.01 c_vin_2_00=0.5098836 \
    r_vin_2_00=57.36408 r_vin_2_2=4.856284 gm_vin_2_vin=0.01 \
    rscl_2_vo_prs=75.44523 g_2_vo=0.1066534 rscl_1_2_prs=40.02803 \
    g_1_2=0.1186879 rscl_vin_1_prs=40.8106 g_vin_1=0.4048205
V0 (net_vin 0) vsource mag=1 type=sine
G_vin_1 (net_1 0 net_vin 0) vccs gm=g_vin_1*1m
R_1_0_prs (net_1 0) resistor r=rscl_vin_1_prs/g_vin_1*1K
C_1_0_prs (net_1 0) capacitor c=g_1_2/6.28*5p
G_1_2 (net_2 0 net_1 0) vccs gm=g_1_2*-1m
R_2_0_prs (net_2 0) resistor r=rscl_1_2_prs/g_1_2*1K
C_2_0_prs (net_2 0) capacitor c=g_2_vo/6.28*5p
G_2_vo (net_vo 0 net_2 0) vccs gm=g_2_vo*1m
R_vo_0_prs (net_vo 0) resistor r=rscl_2_vo_prs/g_2_vo*1K
R_L (net_vo 0) resistor r=0.15M
C_L (net_vo 0) capacitor c=10n
G_vin_2_vin (net_vin_2 0 net_vin 0) vccs gm=gm_vin_2_vin*1m
R_vin_2_2 (net_vin_2 net_2) resistor r=r_vin_2_2*1M
R_vin_2_00 (net_vin_2 0) resistor r=r_vin_2_00/gm_vin_2_vin*1K
C_vin_2_00 (net_vin_2 0) capacitor c=c_vin_2_00*1p
C_input_0 (net_vin 0) capacitor c=gm_vin_2_vin/6.28*5p
G_1_vo_1 (net_1_vo 0 net_1 0) vccs gm=gm_1_vo_1*1m
R_1_vo_vo (net_1_vo net_vo) resistor r=r_1_vo_vo*1M
R_1_vo_02 (net_1_vo 0) resistor r=r_1_vo_02/gm_1_vo_1*1K
C_1_vo_02 (net_1_vo 0) capacitor c=c_1_vo_02*1p
C_input_2 (net_1 0) capacitor c=gm_1_vo_1/6.28*5p
R_1_1_0 (net_1 net_1_0) resistor r=r_1_1_0*1M
C_1_0_0 (net_1_0 0) capacitor c=c_1_0_0*1p
simulatorOptions options reltol=1e-3 vabstol=1e-6 iabstol=1e-12 temp=27 \
    tnom=27 scalem=1.0 scale=1.0 gmin=1e-12 rforce=1 maxnotes=5 maxwarns=5 \
    digits=5 cols=80 pivrel=1e-3 sensfile="../sim_results/psf/sens.output" \
    checklimitdest=psf
ac ac start=1 stop=1G dec=100 annotate=status
modelParameter info what=models where=rawfile
element info what=inst where=rawfile
outputParameter info what=output where=rawfile
designParamVals info what=parameters where=rawfile
primitives info what=primitives where=rawfile
subckts info what=subckts  where=rawfile
save net_vo
saveOptions options save=allpub currents=all saveahdlvars=selected
// Footer end
