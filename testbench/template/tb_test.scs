// Design: my_gm_lib/tb_test
simulator lang=spectre
global 0 vss! vcc!
parameters l5 w5 l4 w4 l1 w1 l0 w0 l3 w3 l2 w2
include "/apps/share/gm_id_mapping/tsmc18rf/1p6m/tsmc18rf/../models/spectre/rf018.scs" section=tt
include "/apps/share/gm_id_mapping/tsmc18rf/1p6m/tsmc18rf/../models/spectre/rf018.scs" section=tt_3v
include "/apps/share/gm_id_mapping/tsmc18rf/1p6m/tsmc18rf/../models/spectre/rf018.scs" section=tt_na
include "/apps/share/gm_id_mapping/tsmc18rf/1p6m/tsmc18rf/../models/spectre/rf018.scs" section=tt_3vna
include "/apps/share/gm_id_mapping/tsmc18rf/1p6m/tsmc18rf/../models/spectre/rf018.scs" section=tt_m
include "/apps/share/gm_id_mapping/tsmc18rf/1p6m/tsmc18rf/../models/spectre/rf018.scs" section=tt_3m
include "/apps/share/gm_id_mapping/tsmc18rf/1p6m/tsmc18rf/../models/spectre/rf018.scs" section=tt_bip
include "/apps/share/gm_id_mapping/tsmc18rf/1p6m/tsmc18rf/../models/spectre/rf018.scs" section=tt_bip3
include "/apps/share/gm_id_mapping/tsmc18rf/1p6m/tsmc18rf/../models/spectre/rf018.scs" section=dio
include "/apps/share/gm_id_mapping/tsmc18rf/1p6m/tsmc18rf/../models/spectre/rf018.scs" section=dio3
include "/apps/share/gm_id_mapping/tsmc18rf/1p6m/tsmc18rf/../models/spectre/rf018.scs" section=dio_dnw
include "/apps/share/gm_id_mapping/tsmc18rf/1p6m/tsmc18rf/../models/spectre/rf018.scs" section=tt_res
include "/apps/share/gm_id_mapping/tsmc18rf/1p6m/tsmc18rf/../models/spectre/rf018.scs" section=tt_mim
include "/apps/share/gm_id_mapping/tsmc18rf/1p6m/tsmc18rf/../models/spectre/rf018.scs" section=tt_rfmos
include "/apps/share/gm_id_mapping/tsmc18rf/1p6m/tsmc18rf/../models/spectre/rf018.scs" section=tt_rfmos33
include "/apps/share/gm_id_mapping/tsmc18rf/1p6m/tsmc18rf/../models/spectre/rf018.scs" section=tt_rfmim
include "/apps/share/gm_id_mapping/tsmc18rf/1p6m/tsmc18rf/../models/spectre/rf018.scs" section=tt_rfind
include "/apps/share/gm_id_mapping/tsmc18rf/1p6m/tsmc18rf/../models/spectre/rf018.scs" section=tt_rfmvar
include "/apps/share/gm_id_mapping/tsmc18rf/1p6m/tsmc18rf/../models/spectre/rf018.scs" section=tt_rfjvar
include "/apps/share/gm_id_mapping/tsmc18rf/1p6m/tsmc18rf/../models/spectre/rf018.scs" section=tt_rfres_sa
include "/apps/share/gm_id_mapping/tsmc18rf/1p6m/tsmc18rf/../models/spectre/rf018.scs" section=tt_rfres_rpo
include "/apps/share/gm_id_mapping/tsmc18rf/1p6m/tsmc18rf/../models/spectre/rf018.scs" section=tt_rfres_hri
include "/apps/share/gm_id_mapping/tsmc18rf/1p6m/tsmc18rf/../models/spectre/rf018.scs" section=tt_rfesd
include "/apps/share/gm_id_mapping/tsmc18rf/1p6m/tsmc18rf/../models/spectre/rf018.scs" section=tt_bbmvar

// my_gm_lib/gm_positive_diff/schematic
subckt gm_positive_diff vdd vin vip vo vss
    M5 (vb vb vss vss) nch l=l5 w=w5 m=1
    M4 (net4 vb vss vss) nch l=l4 w=w4 m=1
    M1 (net5 vin net4 net4) nch l=l1 w=w1 m=1
    M0 (vo vip net4 net4) nch l=l0 w=w0 m=1
    M3 (net5 net5 vdd vdd) pch l=l3 w=w3 m=1
    M2 (vo net5 vdd vdd) pch l=l2 w=w2 m=1
    I2 (vdd vb) isource dc=1u type=dc
ends gm_positive_diff

// my_gm_lib/gm_positive_mid/schematic
subckt gm_positive_mid vdd vi vo vss
    M2 (vb vb vss vss) nch l=l5 w=w5 m=1
    M0 (vo vb vss vss) nch l=l0 w=w0 m=1
    M1 (vo vi vdd vdd) pch l=l1 w=w1 m=1
    I0 (vdd vb) isource dc=1u type=dc
ends gm_positive_mid

// my_gm_lib/tb_test/schematic
I0 (vcc! net7 net6 net8 vss!) gm_positive_diff
I1 (vcc! net8 net5 vss!) gm_positive_mid
V1 (net6 vss!) vsource type=dc
V0 (net7 vss!) vsource type=dc
C0 (net5 vss!) capacitor c=1p
simulatorOptions options temp=27
