// Generated by amp topo opt program
simulator lang=spectre
global 0
// Header end
parameters c_2_0_0=0.5 r_2_2_0=10.0 c_vo_02=1.0 r_vo_02=40.0 \
    gm_vo_1=0.01092684 c_vin_vo_01=0.9999974 r_vin_vo_01=40.0 \
    c_vin_vo_vo=10 gm_vin_vo_vin=0.01 c_vin_2_2=8.516814 \
    r_vin_vin_2=3.081392 rscl_2_vo_prs=80.0 g_2_vo=0.04168711 \
    rscl_1_2_prs=40.56446 g_1_2=0.01 rscl_vin_1_prs=79.9984 \
    g_vin_1=0.1465095
V0 (net_vin 0) vsource mag=1 type=sine
G_vin_1 (net_1 0 net_vin 0) vccs gm=g_vin_1*1m
R_1_0_prs (net_1 0) resistor r=rscl_vin_1_prs/g_vin_1*1K
C_1_0_prs (net_1 0) capacitor c=g_1_2/6.28*5p
G_1_2 (net_2 0 net_1 0) vccs gm=g_1_2*-1m
R_2_0_prs (net_2 0) resistor r=rscl_1_2_prs/g_1_2*1K
C_2_0_prs (net_2 0) capacitor c=g_2_vo/6.28*5p
G_2_vo (net_vo 0 net_2 0) vccs gm=g_2_vo*1m
R_vo_0_prs (net_vo 0) resistor r=rscl_2_vo_prs/g_2_vo*1K
R_L (net_vo 0) resistor r=0.15M
C_L (net_vo 0) capacitor c=10n
R_vin_vin_2 (net_vin net_vin_2) resistor r=r_vin_vin_2*1M
C_vin_2_2 (net_vin_2 net_2) capacitor c=c_vin_2_2*1p
G_vin_vo_vin (net_vin_vo 0 net_vin 0) vccs gm=gm_vin_vo_vin*-1m
C_vin_vo_vo (net_vin_vo net_vo) capacitor c=c_vin_vo_vo*1p
R_vin_vo_01 (net_vin_vo 0) resistor r=r_vin_vo_01/gm_vin_vo_vin*1K
C_vin_vo_01 (net_vin_vo 0) capacitor c=c_vin_vo_01*1p
C_input_1 (net_vin 0) capacitor c=gm_vin_vo_vin/6.28*5p
G_vo_1 (net_vo 0 net_1 0) vccs gm=gm_vo_1*-1m
R_vo_02 (net_vo 0) resistor r=r_vo_02/gm_vo_1*1K
C_vo_02 (net_vo 0) capacitor c=c_vo_02*1p
C_input_2 (net_1 0) capacitor c=gm_vo_1/6.28*5p
R_2_2_0 (net_2 net_2_0) resistor r=r_2_2_0*1M
C_2_0_0 (net_2_0 0) capacitor c=c_2_0_0*1p
simulatorOptions options reltol=1e-3 vabstol=1e-6 iabstol=1e-12 temp=27 \
    tnom=27 scalem=1.0 scale=1.0 gmin=1e-12 rforce=1 maxnotes=5 maxwarns=5 \
    digits=5 cols=80 pivrel=1e-3 sensfile="../sim_results/psf/sens.output" \
    checklimitdest=psf
ac ac start=1 stop=1G dec=100 annotate=status
modelParameter info what=models where=rawfile
element info what=inst where=rawfile
outputParameter info what=output where=rawfile
designParamVals info what=parameters where=rawfile
primitives info what=primitives where=rawfile
subckts info what=subckts  where=rawfile
save net_vo
saveOptions options save=allpub currents=all saveahdlvars=selected
// Footer end
